* ISLAM LAB reference: underdamped series RLC driven by a 1 V step
* Values: R=100 ohm, L=10 mH, C=1 uF; sample 0.2 ms after the step.
VSTEP in 0 PULSE(0 1 1m 1n 1n 10m 20m)
R1 in n1 100
L1 n1 out 10m
C1 out 0 1u
.tran 1u 1.5m
.meas tran v_tau FIND v(out) AT=1.2m
.end
